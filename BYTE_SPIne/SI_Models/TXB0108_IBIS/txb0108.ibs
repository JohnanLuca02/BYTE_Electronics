| TEXAS INSTRUMENTS INCORPORATED
| Standard Linear and Logic Group / High Volume Linear
| IBIS Model of TXB0108
| 8-BIT BIDIRECTIONAL VOLTAGE LEVEL TRANSLATOR WITH AUTO DIRECTION
| SENSING AND 15kV ESD
| This file contains package information for the following:
|  QFN 20-pin (RGY) package as [Component] TXB0108RGY_QFN
|  YZP 20-pin (PW) package as [Component] TXB0108YZP_PW
|  BGA 20-pin (ZXY) package as [Component] TXB0108YZP_ZXY
| This device can be powered at the following Vccs:
|  1.2 volt Vcc
|  1.5 volt Vcc
|  1.8 volt Vcc
|  2.5 volt Vcc
|  3.3 volt Vcc
|  5 volt Vcc
| This file provides unique models under the [Model Selector] for each Vcc.
| For operation at a specific Vcc, select the appropriate model after each
| [Model Selector] keyword.
[IBIS Ver]   4.0
[Comment char]  |_char
[File Name]   txb0108.ibs
[File Rev]   1.7 | a-die
[Date]   July 14, 2014
[Source]   Data created from TI-SPICE simulations at TI-SLL/HVL.
   The following is an IBIS list for the TXB0108.
   Please contact sllibis@ti.com with questions and
   comments concerning SLL IBIS models.
[Notes]   Revision_History:
   Since the voltage level for A ports and B ports are
   different,for A side port, the voltage range is 1.2V to
   3.3V, for B side port, the voltage range is 1.8V to 5V. In
   the model file, the model only contain the node voltage in
   the corresponding range.
   - FILE REV HISTORY
   - 1.7 07/14/14   Added DQS package component
   - 1.6 06/19/12   Added models for one-shot circuit on
   - 1.5 03/05/12   Change 3-state to I/O with Vih/Vil limits
   - 1.4 02/29/12   Update with new package information
   - 1.3 09/01/11   Update new package information
   - 1.2 08/02/10   Release IBIS file
   - As there is no power clamp diode we removed the Power Clamp
   table data from the IN and I/O Models.
   - IBIS SYNTAX CANNOT DESCRIBE THE CHARACTERISTICS OF
   ANY OUTPUT STRUCTURES THAT DYNAMICALLY CHANGES THE
   IMPEDANCES DURING THE TRANSITION. THIS DEVICE USE SIMILAR
   OUTPUT STRUCTURE AND THEREFORE THE SIMULATION RESULTS
   MAY NOT BE ACCURATE. TI RECOMMENDS THE USE OF SPICE
   SIMULATION WHEN SIMULATION ACCURACY IS IMPORTANT.
   - Please note that models for one shot circuit on can be chosen under
   [Model Selector] for TXB0108B_IOA and TXB0108B_IOB models.
   TXB0108B_IOx_xx Pullup and Pulldown are non-monotonic
[Disclaimer]
| This model is designed as an aid for customers of Texas Instruments.
| TI and its licensors and suppliers make no warranties, either expressed
| or implied, with respect to this  model, including the warranties of
| merchantability or fitness for a particular purpose. The model is
| provided solely on an "as is" basis. The entire risk as to its quality
| and performance is with the customer.
[Copyright]
| (C) Copyright 2014 Texas Instruments Incorporated. All rights reserved.
| Component TXB0108RGY_QFN 20-PIN QFN
[Component]   TXB0108RGY_QFN
[Manufacturer]   Texas Instruments, Inc.
[Package]
|   typ   min   max
R_pkg   5.000e-02   4.600e-02   5.500e-02
L_pkg   1.119e-09   1.025e-09   1.227e-09
C_pkg   3.520e-13   3.440e-13   3.630e-13
[Pin]   signal_name   model_name   R_pin   L_pin   C_pin
1   A1   TXB0108B_IOA   5.200e-02   1.167e-09   3.600e-13
2   VCCA   POWER   4.700e-02   1.049e-09   3.440e-13
3   A2   TXB0108B_IOA   4.700e-02   1.055e-09   3.450e-13
4   A3   TXB0108B_IOA   5.000e-02   1.119e-09   3.500e-13
5   A4   TXB0108B_IOA   5.500e-02   1.227e-09   3.600e-13
6   A5   TXB0108B_IOA   5.200e-02   1.167e-09   3.550e-13
7   A6   TXB0108B_IOA   4.900e-02   1.087e-09   3.480e-13
8   A7   TXB0108B_IOA   4.700e-02   1.054e-09   3.460e-13
9   A8   TXB0108B_IOA   4.900e-02   1.091e-09   3.490e-13
10   OE   TXB0108B_IN   5.300e-02   1.184e-09   3.620e-13
11   GND   GND   5.300e-02   1.181e-09   3.600e-13
12   B8   TXB0108B_IOB   5.000e-02   1.108e-09   3.490e-13
13   B7   TXB0108B_IOB   4.800e-02   1.075e-09   3.470e-13
14   B6   TXB0108B_IOB   5.000e-02   1.107e-09   3.490e-13
15   B5   TXB0108B_IOB   5.400e-02   1.200e-09   3.620e-13
16   B4   TXB0108B_IOB   5.100e-02   1.141e-09   3.570e-13
17   B3   TXB0108B_IOB   4.700e-02   1.043e-09   3.440e-13
18   B2   TXB0108B_IOB   4.600e-02   1.025e-09   3.440e-13
19   VCCB   POWER   4.900e-02   1.090e-09   3.490e-13
20   B1   TXB0108B_IOB   5.400e-02   1.204e-09   3.630e-13
| Component TXB0108YZP_PW 20-PIN YZP
[Component]   TXB0108YZP_PW
[Manufacturer]   Texas Instruments, Inc.
[Package]
|   typ   min   max
R_pkg   5.500e-02   1.300e-02   9.500e-02
L_pkg   3.400e-10   1.850e-10   5.300e-10
C_pkg   4.400e-13   4.030e-13   4.970e-13
[Pin]   signal_name   model_name   R_pin   L_pin   C_pin
1   B2   TXB0108B_IOB   9.500e-02   4.850e-10   4.710e-13
2   B1   TXB0108B_IOB   1.600e-02   1.920e-10   4.070e-13
3   A1   TXB0108B_IOA   4.700e-02   3.040e-10   4.330e-13
4   A2   TXB0108B_IOA   6.800e-02   3.860e-10   4.480e-13
5   B4   TXB0108B_IOB   5.700e-02   3.440e-10   4.390e-13
6   B3   TXB0108B_IOB   8.400e-02   4.390e-10   4.630e-13
7   A3   TXB0108B_IOA   7.300e-02   4.020e-10   4.550e-13
8   A4   TXB0108B_IOA   6.500e-02   3.740e-10   4.450e-13
9   VCC   POWER   1.300e-02   1.850e-10   4.030e-13
10   B5   TXB0108B_IOB   9.300e-02   5.300e-10   4.970e-13
11   A5   TXB0108B_IOA   9.100e-02   4.950e-10   4.820e-13
12   VCC   POWER   4.800e-02   3.120e-10   4.310e-13
13   GND   GND   3.200e-02   2.530e-10   4.180e-13
14   B7   TXB0108B_IOB   6.200e-02   3.610e-10   4.450e-13
15   A7   TXB0108B_IOA   3.900e-02   2.780e-10   4.270e-13
16   OE   TXB0108B_IN   6.400e-02   3.700e-10   4.440e-13
17   B8   TXB0108B_IOB   4.000e-02   2.820e-10   4.250e-13
18   B6   TXB0108B_IOB   3.200e-02   2.490e-10   4.200e-13
19   A6   TXB0108B_IOA   2.200e-02   2.120e-10   4.120e-13
20   A8   TXB0108B_IOA   5.900e-02   3.510e-10   4.400e-13
| Component TXB0108_ZXY 20-PIN u*Jr BGA
[Component]   TXB0108_ZXY
[Manufacturer]   Texas Instruments, Inc.
[Package]
|   typ   min   max
R_pkg   0.057703   0.05127   0.06781
L_pkg   1.1577665n  0.99154n   1.48216n
C_pkg   0.1802725p  0.13673p   0.22855p
[Pin]   signal_name   model_name   R_pin   L_pin   C_pin
1   A8   TXB0108B_IOA   0.05373   1.01871n   0.15665p
2   A7   TXB0108B_IOA   0.06276   1.39916n   0.21753p
3   A6   TXB0108B_IOA   0.05433   1.01804n   0.18684p
4   A5   TXB0108B_IOA   0.06043   1.35595n   0.22385p
5   A4   TXB0108B_IOA   0.05268   0.99154n   0.18368p
6   A3   TXB0108B_IOA   0.05974   1.35105n   0.21539p
7   A2   TXB0108B_IOA   0.05308   1.00780n   0.16664p
8   VCCA   POWER   0.05705   1.02274n   0.16511p
9   A1   TXB0108B_IOA   0.05192   1.03338n   0.13766p
10   B1   TXB0108B_IOB   0.05127   1.02319n   0.13673p
11   VCCB   POWER   0.06180   1.16248n   0.14894p
12   B2   TXB0108B_IOB   0.05734   1.07561n   0.17217p
13   B3   TXB0108B_IOB   0.06444   1.42639n   0.22198p
14   B4   TXB0108B_IOB   0.05770   1.07442n   0.18915p
15   B5   TXB0108B_IOB   0.06564   1.44558n   0.22855p
16   B6   TXB0108B_IOB   0.05938   1.10463n   0.19337p
17   B7   TXB0108B_IOB   0.06781   1.48216n   0.22458p
18   B8   TXB0108B_IOB   0.05895   1.10793n   0.16240p
19   GND   GND   0.05168   1.02154n   0.13715p
20   OE   TXB0108B_IN   0.05233   1.03303n   0.13708p
| Component TXB0108DQS 20-PIN USON
[Component]   TXB0108DQS
[Manufacturer]   Texas Instruments, Inc.
[Package]   | 20 USON - DQS
|   typ   min   max
R_pkg   0.0709   0.0476   0.1201
L_pkg   0.7671n   0.5267n   1.2773
C_pkg   0.0743p   0.0601p   0.0978
[Pin]   signal_name   model_name   R_pin   L_pin   C_pin
1   A1   TXB0108B_IOA   0.11909   1.26105n   0.09780p
2   A2   TXB0108B_IOA   0.07937   0.84797n   0.08320p
3   A3   TXB0108B_IOA   0.05618   0.61232n   0.06639p
4   A4   TXB0108B_IOA   0.05233   0.57346n   0.06362p
5   VCCA   POWER   0.04760   0.52667n   0.06012p
6   OE   TXB0108B_IN   0.04802   0.53080n   0.06022p
7   A5   TXB0108B_IOA   0.04930   0.54345n   0.06103p
8   A6   TXB0108B_IOA   0.05094   0.56005n   0.06286p
9   A7   TXB0108B_IOA   0.07885   0.84272n   0.08337p
10   A8   TXB0108B_IOA   0.11720   1.24147n   0.09653p
11   B8   TXB0108B_IOB   0.11943   1.27035n   0.09668p
12   B7   TXB0108B_IOB   0.07325   0.79077n   0.07858p
13   B6   TXB0108B_IOB   0.06118   0.66741n   0.07041p
14   B5   TXB0108B_IOB   0.05548   0.61022n   0.06664p
15   GND   GND   0.04765   0.53369n   0.06097p
16   VCCB   POWER   0.05059   0.56209n   0.06289p
17   B4   TXB0108B_IOB   0.05623   0.61769n   0.06684p
18   B3   TXB0108B_IOB   0.06211   0.67674n   0.07114p
19   B2   TXB0108B_IOB   0.07372   0.79545n   0.07903p
20   B1   TXB0108B_IOB   0.12010   1.27725n   0.09727p
| Model TXB0108B_IN
[Model Selector]   TXB0108B_IN
TXB0108B_IN_12   1.2 volt Vcc
TXB0108B_IN_15   1.5 volt Vcc
TXB0108B_IN_18   1.8 volt Vcc
TXB0108B_IN_25   2.5 volt Vcc
TXB0108B_IN_33   3.3 volt Vcc
TXB0108B_IN_50   5 volt Vcc
| Model TXB0108B_IOA
[Model Selector]   TXB0108B_IOA
TXB0108B_IOA_12   1.2 volt Vcc
TXB0108B_IOA_15   1.5 volt Vcc
TXB0108B_IOA_18   1.8 volt Vcc
TXB0108B_IOA_25   2.5 volt Vcc
TXB0108B_IOA_33   3.3 volt Vcc
TXB0108_IOA_OS_12   one shot circuit on at  1.2 volt Vcc
TXB0108_IOA_OS_15   one shot circuit on at 1.5 volt Vcc
TXB0108_IOA_OS_18   one shot circuit on at 1.8 volt Vcc
TXB0108_IOA_OS_25   one shot circuit on at 2.5 volt Vcc
TXB0108_IOA_OS_33   one shot circuit on at 3.3 volt Vcc
| Model TXB0108B_IOB
[Model Selector]   TXB0108B_IOB
TXB0108B_IOB_18   1.8 volt Vcc
TXB0108B_IOB_25   2.5 volt Vcc
TXB0108B_IOB_33   3.3 volt Vcc
TXB0108B_IOB_50   5 volt Vcc
TXB0108_IOB_OS_18   one shot circuit on at 1.8 volt Vcc
TXB0108_IOB_OS_25   one shot circuit on at 2.5 volt Vcc
TXB0108_IOB_OS_33   one shot circuit on  at 3.3 volt Vcc
TXB0108_IOB_OS_50   one shot circuit on  at 5 volt Vcc
| Models and submodels in the file (24): TXB0108B_IN_12 (Input), TXB0108B_IN_15 (Input), TXB0108B_IN_18 (Input), TXB0108B_IN_25 (Input), TXB0108B_IN_33 (Input), TXB0108B_IN_50 (Input), TXB0108B_IOA_12 (I/O), TXB0108B_IOA_15 (I/O), TXB0108B_IOA_18 (I/O), TXB0108B_IOA_25 (I/O), TXB0108B_IOA_33 (I/O), TXB0108B_IOB_18 (I/O), TXB0108B_IOB_25 (I/O), TXB0108B_IOB_33 (I/O), TXB0108B_IOB_50 (I/O), TXB0108_IOB_OS_50 (I/O), TXB0108_IOB_OS_33 (I/O), TXB0108_IOB_OS_25 (I/O), TXB0108_IOB_OS_18 (I/O), TXB0108_IOA_OS_33 (I/O), TXB0108_IOA_OS_25 (I/O), TXB0108_IOA_OS_18 (I/O), TXB0108_IOA_OS_15 (I/O), TXB0108_IOA_OS_12 (I/O)
