|   stm32f0_448_lqfp48 IBIS Model
[IBIS ver]   4.2
[File name]  stm32f0_448_lqfp48.ibs
[File Rev]   1.0
[Date]   15-5-2013
[Source] Data Created at STMicroelectronics
[Notes]   File originated from ELDO simulations.
[Disclaimer]  This information is for modeling purpose only and is
   not guaranted. The information is subject to change without
   notice.
[Copyright] Copyright 2015 STMicroelectronics Inc.
[Component] stm32f0_448_lqfp48
[Manufacturer] STMicroelectronics
[Package]
| variable   typ   min   max
R_pkg   0.0   NA   NA
L_pkg   0.0H   NA   NA
C_pkg   0.0F   NA   NA
[Pin] signal_name  model_name   R_pin   L_pin   C_pin
1   VBAT   POWER   69.0E-3   4.2E-9   120.0E-15
2   PC13   io8p_sudq_tc   61.9E-3   3.5E-9   84.0E-15
3   PC14   io8p_sudq_tc   56.4E-3   2.9E-9   56.0E-15
4   PC15   io8p_sudq_tc   52.4E-3   2.5E-9   36.0E-15
5   PF0   io8p_sudq_ft   50.1E-3   2.3E-9   24.0E-15
6   PF1   io8p_sudq_ft   49.3E-3   2.2E-9   20.0E-15
7   NRST   ioreset_tc_v33   49.3E-3   2.2E-9   20.0E-15
8   VSSA   GND   50.1E-3   2.3E-9   24.0E-15
9   VDDA   POWER   52.4E-3   2.5E-9   36.0E-15
10   PA0   io8p_sudq_ft   56.4E-3   2.9E-9   56.0E-15
11   PA1   io8p_sudq_ft   61.9E-3   3.5E-9   84.0E-15
12   PA2   io8p_sudq_ft   69.0E-3   4.2E-9   120.0E-15
13   PA3   io8p_sudq_ft   69.0E-3   4.2E-9   120.0E-15
14   PA4   io8p_sudq_ft   61.9E-3   3.5E-9   84.0E-15
15   PA5   io8p_sudq_ft   56.4E-3   2.9E-9   56.0E-15
16   PA6   io8p_sudq_ft   52.4E-3   2.5E-9   36.0E-15
17   PA7   io8p_sudq_ft   50.1E-3   2.3E-9   24.0E-15
18   PB0   io8p_sudq_ft   49.3E-3   2.2E-9   20.0E-15
19   PB1   io8p_sudq_ft   49.3E-3   2.2E-9   20.0E-15
20   PB2   io8p_sudq_ft   50.1E-3   2.3E-9   24.0E-15
21   PB10   io8p_sudq_i2cin_lv_ft   52.4E-3   2.5E-9   36.0E-15
22   PB11   io8p_sudq_i2cin_lv_ft   56.4E-3   2.9E-9   56.0E-15
23   VSS   GND   61.9E-3   3.5E-9   84.0E-15
24   VDD   POWER   69.0E-3   4.2E-9   120.0E-15
25   PB12   io8p_sudq_ft   69.0E-3   4.2E-9   120.0E-15
26   PB13   io8p_sudq_ft   61.9E-3   3.5E-9   84.0E-15
27   PB14   io8p_sudq_ft   56.4E-3   2.9E-9   56.0E-15
28   PB15   io8p_sudq_ft   52.4E-3   2.5E-9   36.0E-15
29   PA8   io8p_sudq_ft   50.1E-3   2.3E-9   24.0E-15
30   PA9   io8p_sudq_ft   49.3E-3   2.2E-9   20.0E-15
31   PA10   io8p_sudq_ft   49.3E-3   2.2E-9   20.0E-15
32   PA11   io8p_sudq_ft   50.1E-3   2.3E-9   24.0E-15
33   PA12   io8p_sudq_ft   52.4E-3   2.5E-9   36.0E-15
34   PA13   io8p_sudq_ft   56.4E-3   2.9E-9   56.0E-15
35   VSS   GND   61.9E-3   3.5E-9   84.0E-15
36   VDDIO2   POWER   69.0E-3   4.2E-9   120.0E-15
37   PA14   io8p_sudq_ft   69.0E-3   4.2E-9   120.0E-15
38   PA15   io8p_sudq_ft   61.9E-3   3.5E-9   84.0E-15
39   PB3   io8p_sudq_ft   56.4E-3   2.9E-9   56.0E-15
40   PB4   io8p_sudq_ft   52.4E-3   2.5E-9   36.0E-15
41   PB5   io8p_sudq_ft   50.1E-3   2.3E-9   24.0E-15
42   PB6   io8p_sudq_i2cin_lv_ft   49.3E-3   2.2E-9   20.0E-15
43   PB7   io8p_sudq_i2cin_lv_ft   49.3E-3   2.2E-9   20.0E-15
44   BOOT0   vpp_test_hv   50.1E-3   2.3E-9   24.0E-15
45   PB8   io8p_sudq_i2cin_lv_ft   52.4E-3   2.5E-9   36.0E-15
46   PB9   io8p_sudq_i2cin_lv_ft   56.4E-3   2.9E-9   56.0E-15
47   VSS   GND   61.9E-3   3.5E-9   84.0E-15
48   VDD   POWER   69.0E-3   4.2E-9   120.0E-15
[Model Selector] io8p_sudq_ft
io8p01_sudq_ft_pd_lv  "SPEED01 2P0V, PD=40kOhm"
io8p01_sudq_ft_pu_lv  "SPEED01 2P0V, PU=40kOhm"
io8p01_sudq_ft_lv  "SPEED01 2P0V"
io8p10_sudq_ft_pd_lv  "SPEED10 2P0V, PD=40kOhm"
io8p10_sudq_ft_pu_lv  "SPEED10 2P0V, PU=40kOhm"
io8p10_sudq_ft_lv  "SPEED10 2P0V"
io8p11_sudq_ft_pd_lv  "SPEED11 2P0V, PD=40kOhm"
io8p11_sudq_ft_pu_lv  "SPEED11 2P0V, PU=40kOhm"
io8p11_sudq_ft_lv  "SPEED11 2P0V"
io8p01_sudq_ft_pd  "SPEED01, PD=40kOhm"
io8p01_sudq_ft_pu  "SPEED01, PU=40kOhm"
io8p01_sudq_ft  "SPEED01"
io8p10_sudq_ft_pd  "SPEED10, PD=40kOhm"
io8p10_sudq_ft_pu  "SPEED10, PU=40kOhm"
io8p10_sudq_ft  "SPEED10"
io8p11_sudq_ft_pd  "SPEED11, PD=40kOhm"
io8p11_sudq_ft_pu  "SPEED11, PU=40kOhm"
io8p11_sudq_ft  "SPEED11"
[Model Selector] io8p_sudq_i2cin_lv_ft
io8p01_sudq_i2cin_lv_ft_pd_lv  "SPEED01 2P0V, PD=40kOhm"
io8p01_sudq_i2cin_lv_ft_pu_lv  "SPEED01 2P0V, PU=40kOhm"
io8p01_sudq_i2cin_lv_ft_lv  "SPEED01 2P0V"
io8p10_sudq_i2cin_lv_ft_pd_lv  "SPEED10 2P0V, PD=40kOhm"
io8p10_sudq_i2cin_lv_ft_pu_lv  "SPEED10 2P0V, PU=40kOhm"
io8p10_sudq_i2cin_lv_ft_lv  "SPEED10 2P0V"
io8p11_sudq_i2cin_lv_ft_pd_lv  "SPEED11 2P0V, PD=40kOhm"
io8p11_sudq_i2cin_lv_ft_pu_lv  "SPEED11 2P0V, PU=40kOhm"
io8p11_sudq_i2cin_lv_ft_lv  "SPEED11 2P0V"
io8p01_sudq_i2cin_lv_ft_pd  "SPEED01, PD=40kOhm"
io8p01_sudq_i2cin_lv_ft_pu  "SPEED01, PU=40kOhm"
io8p01_sudq_i2cin_lv_ft  "SPEED01"
io8p10_sudq_i2cin_lv_ft_pd  "SPEED10, PD=40kOhm"
io8p10_sudq_i2cin_lv_ft_pu  "SPEED10, PU=40kOhm"
io8p10_sudq_i2cin_lv_ft  "SPEED10"
io8p11_sudq_i2cin_lv_ft_pd  "SPEED11, PD=40kOhm"
io8p11_sudq_i2cin_lv_ft_pu  "SPEED11, PU=40kOhm"
io8p11_sudq_i2cin_lv_ft  "SPEED11"
[Model Selector] io8p_sudq_tc
io8p01_sudq_tc_pd_lv  "SPEED01 2P0V, PD=40kOhm"
io8p01_sudq_tc_pu_lv  "SPEED01 2P0V, PU=40kOhm"
io8p01_sudq_tc_lv  "SPEED01 2P0V"
io8p10_sudq_tc_pd_lv  "SPEED10 2P0V, PD=40kOhm"
io8p10_sudq_tc_pu_lv  "SPEED10 2P0V, PU=40kOhm"
io8p10_sudq_tc_lv  "SPEED10 2P0V"
io8p11_sudq_tc_pd_lv  "SPEED11 2P0V, PD=40kOhm"
io8p11_sudq_tc_pu_lv  "SPEED11 2P0V, PU=40kOhm"
io8p11_sudq_tc_lv  "SPEED11 2P0V"
io8p01_sudq_tc_pd  "SPEED01, PD=40kOhm"
io8p01_sudq_tc_pu  "SPEED01, PU=40kOhm"
io8p01_sudq_tc  "SPEED01"
io8p10_sudq_tc_pd  "SPEED10, PD=40kOhm"
io8p10_sudq_tc_pu  "SPEED10, PU=40kOhm"
io8p10_sudq_tc  "SPEED10"
io8p11_sudq_tc_pd  "SPEED11, PD=40kOhm"
io8p11_sudq_tc_pu  "SPEED11, PU=40kOhm"
io8p11_sudq_tc  "SPEED11"
[Model Selector] ioreset_tc_v33
ioreset_tc_v33_pu_lv  "IORESET 2V + PU=40kOhm"
ioreset_tc_v33_nopu_lv  "IORESET 2V"
ioreset_tc_v33_pu  "IORESET + PU=40kOhm"
ioreset_tc_v33_nopu  "IORESET"
[Model Selector] vpp_test_hv
vpp_test_hv_3p3  "Input Buffer"
vpp_test_hv_2p4  "Input Buffer 2P0V"
| Models and submodels in the file (60): io8p01_sudq_ft_pd_lv (I/O), io8p01_sudq_ft_pu_lv (I/O), io8p01_sudq_ft_lv (I/O), io8p10_sudq_ft_pd_lv (I/O), io8p10_sudq_ft_pu_lv (I/O), io8p10_sudq_ft_lv (I/O), io8p11_sudq_ft_pd_lv (I/O), io8p11_sudq_ft_pu_lv (I/O), io8p11_sudq_ft_lv (I/O), io8p01_sudq_ft_pd (I/O), io8p01_sudq_ft_pu (I/O), io8p01_sudq_ft (I/O), io8p10_sudq_ft_pd (I/O), io8p10_sudq_ft_pu (I/O), io8p10_sudq_ft (I/O), io8p11_sudq_ft_pd (I/O), io8p11_sudq_ft_pu (I/O), io8p11_sudq_ft (I/O), io8p01_sudq_i2cin_lv_ft_pd_lv (I/O), io8p01_sudq_i2cin_lv_ft_pu_lv (I/O), io8p01_sudq_i2cin_lv_ft_lv (I/O), io8p10_sudq_i2cin_lv_ft_pd_lv (I/O), io8p10_sudq_i2cin_lv_ft_pu_lv (I/O), io8p10_sudq_i2cin_lv_ft_lv (I/O), io8p11_sudq_i2cin_lv_ft_pd_lv (I/O), io8p11_sudq_i2cin_lv_ft_pu_lv (I/O), io8p11_sudq_i2cin_lv_ft_lv (I/O), io8p01_sudq_i2cin_lv_ft_pd (I/O), io8p01_sudq_i2cin_lv_ft_pu (I/O), io8p01_sudq_i2cin_lv_ft (I/O), io8p10_sudq_i2cin_lv_ft_pd (I/O), io8p10_sudq_i2cin_lv_ft_pu (I/O), io8p10_sudq_i2cin_lv_ft (I/O), io8p11_sudq_i2cin_lv_ft_pd (I/O), io8p11_sudq_i2cin_lv_ft_pu (I/O), io8p11_sudq_i2cin_lv_ft (I/O), io8p01_sudq_tc_pd_lv (I/O), io8p01_sudq_tc_pu_lv (I/O), io8p01_sudq_tc_lv (I/O), io8p10_sudq_tc_pd_lv (I/O), io8p10_sudq_tc_pu_lv (I/O), io8p10_sudq_tc_lv (I/O), io8p11_sudq_tc_pd_lv (I/O), io8p11_sudq_tc_pu_lv (I/O), io8p11_sudq_tc_lv (I/O), io8p01_sudq_tc_pd (I/O), io8p01_sudq_tc_pu (I/O), io8p01_sudq_tc (I/O), io8p10_sudq_tc_pd (I/O), io8p10_sudq_tc_pu (I/O), io8p10_sudq_tc (I/O), io8p11_sudq_tc_pd (I/O), io8p11_sudq_tc_pu (I/O), io8p11_sudq_tc (I/O), ioreset_tc_v33_pu_lv (I/O_open_drain), ioreset_tc_v33_nopu_lv (I/O_open_drain), ioreset_tc_v33_pu (I/O_open_drain), ioreset_tc_v33_nopu (I/O_open_drain), vpp_test_hv_2p4 (Input), vpp_test_hv_3p3 (Input)
